* ac_v

Vz z 0 AC 1
R7 z v 11k
R8 v 0 13k
C9 v 0 27n
.ac dec 200 10 20k

.model BAT85 D(IS=1.3e-8 N=1.1 RS=2 CJO=10p BV=30 IBV=2u)
.model D1N5819 D(IS=31.7u N=1.373 RS=0.051 CJO=110p M=0.35 EG=0.69 XTI=2 BV=40 IBV=1m)

.control
set wr_singlescale
set wr_vecnames
run
wrdata /home/davixcky/dev/.personal/electronica/sistemas-embebidos-1/C2-ABPR/herramientas/../simulacion/ac_v.dat vm(v) vp(v)
.endc
.end
