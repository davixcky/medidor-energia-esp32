* ac_ch1

Vb vb 0 1.32
Ict vb t AC 1
Rb t vb 22
R5 t a 3.3k
C5 a vb 47n
.ac dec 200 10 20k

.model BAT85 D(IS=1.3e-8 N=1.1 RS=2 CJO=10p BV=30 IBV=2u)
.model D1N5819 D(IS=31.7u N=1.373 RS=0.051 CJO=110p M=0.35 EG=0.69 XTI=2 BV=40 IBV=1m)

.control
set wr_singlescale
set wr_vecnames
run
wrdata /home/davixcky/dev/.personal/electronica/medidor-energia-esp32/herramientas/../simulacion/ac_ch1.dat vm(a) vp(a)
.endc
.end
